ADE simulation setup
Test lablib:nine_bit_counter_TB:1: lablib/nine_bit_counter_TB/schematic, simulator spectre
  Models: $CDK_DIR/models/spectre/standalone/tsmc25N.m, $CDK_DIR/models/spectre/standalone/tsmc25P.m, $CDK_DIR/models/spectre/standalone/tsmc35N.m, $CDK_DIR/models/spectre/standalone/tsmc35P.m, $CDK_DIR/models/spectre/standalone/ami06N.m, $CDK_DIR/models/spectre/standalone/ami06P.m
  Temperature: 27
  Analysis tran: stop=300u
  Signals: /clk, /rstn, /out<0>, /out<1>, /out<2>, /out<3>, /out<4>, /out<5>, /out<6>, /out<7>, /out<8>
Run mode: Single Run, Sweeps and Corners
