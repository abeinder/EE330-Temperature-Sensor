ADE simulation setup
Run mode: Single Run, Sweeps and Corners
Tests:
  lablib:nine_bit_counter_TB:1: lablib/nine_bit_counter_TB/schematic, simulator spectre
