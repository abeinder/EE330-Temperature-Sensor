ADE simulation setup
Run mode: Single Run, Sweeps and Corners
Tests:
  lablib:FinalProject_tempsensor:1: lablib/FinalProject_tempsensor/schematic, simulator spectre
