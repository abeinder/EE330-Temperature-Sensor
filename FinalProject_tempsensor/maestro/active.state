ADE simulation setup
Test lablib:FinalProject_tempsensor:1: lablib/FinalProject_tempsensor/schematic, simulator spectre
  Models: $CDK_DIR/models/spectre/standalone/tsmc25N.m, $CDK_DIR/models/spectre/standalone/tsmc25P.m, $CDK_DIR/models/spectre/standalone/tsmc35N.m, $CDK_DIR/models/spectre/standalone/tsmc35P.m, $CDK_DIR/models/spectre/standalone/ami06N.m, $CDK_DIR/models/spectre/nom/ami06N.m, $CDK_DIR/models/spectre/nom/ami06P.m
  Analysis dc: sweep temperature start=-20 stop=100 (saves the operating point)
  Signals: /Vref, /M1/D (terminal), /M0/D (terminal), /P15/S (terminal)
Run mode: Single Run, Sweeps and Corners
