ADE simulation setup
Test lablib:FinalProject_ADC_TB:1: lablib/FinalProject_ADC_TB/schematic, simulator spectre
  Models: $CDK_DIR/models/spectre/standalone/tsmc25N.m, $CDK_DIR/models/spectre/standalone/tsmc25P.m, $CDK_DIR/models/spectre/standalone/tsmc35N.m, $CDK_DIR/models/spectre/standalone/tsmc35P.m, $CDK_DIR/models/spectre/standalone/ami06N.m, $CDK_DIR/models/spectre/standalone/ami06P.m
  Temperature: 27
  Analysis tran: stop=4m
  Signals: /vref, /clk, /vout<0>, /vout<1>, /vout<2>, /vout<3>, /vout<4>, /vout<5>, /vout<6>
Run mode: Single Run, Sweeps and Corners
