ADE simulation setup
Run mode: Single Run, Sweeps and Corners
Tests:
  lablib:FinalProject_ADC_TB:1: lablib/FinalProject_ADC_TB/schematic, simulator spectre
