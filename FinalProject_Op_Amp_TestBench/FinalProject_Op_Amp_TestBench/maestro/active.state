ADE simulation setup
Test lablib:FinalProject_Op_Amp_TestBench:1: lablib/FinalProject_Op_Amp_TestBench/schematic, simulator spectre
  Models: $CDK_DIR/models/spectre/standalone/tsmc25N.m, $CDK_DIR/models/spectre/standalone/tsmc25P.m, $CDK_DIR/models/spectre/standalone/tsmc35N.m, $CDK_DIR/models/spectre/standalone/tsmc35P.m, $CDK_DIR/models/spectre/standalone/ami06N.m, $CDK_DIR/models/spectre/nom/ami06N.m, $CDK_DIR/models/spectre/nom/ami06P.m
  Temperature: 27
  Analysis stb: start=1 stop=1G dec=10 probe=/IPRB0 stbProbeMode=differential
  Analysis dc: (saves the operating point)
  Output Loop Gain Phase = phaseDegUnwrapped(getData("loopGain" ?result "stb"))
  Output Loop Gain dB20 = db(mag(getData("loopGain" ?result "stb")))
  Signals: /Vout, /CC, /Vin
Run mode: Single Run, Sweeps and Corners
