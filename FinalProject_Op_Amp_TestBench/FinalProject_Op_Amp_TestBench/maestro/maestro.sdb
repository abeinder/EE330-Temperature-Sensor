ADE simulation setup
Run mode: Single Run, Sweeps and Corners
Tests:
  lablib:FinalProject_Op_Amp_TestBench:1: lablib/FinalProject_Op_Amp_TestBench/schematic, simulator spectre
