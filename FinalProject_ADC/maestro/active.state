ADE simulation setup
Test lablib:FinalProject_ADC:1: lablib/FinalProject_ADC/schematic, simulator spectre
  Models: $CDK_DIR/models/spectre/standalone/tsmc25N.m, $CDK_DIR/models/spectre/standalone/tsmc25P.m, $CDK_DIR/models/spectre/standalone/tsmc35N.m, $CDK_DIR/models/spectre/standalone/tsmc35P.m, $CDK_DIR/models/spectre/standalone/ami06N.m, $CDK_DIR/models/spectre/nom/ami06P.m, $CDK_DIR/models/spectre/nom/ami06N.m
  Variables: Vin = 500m; Vrefx = .1m; C = 1u; R = 100k
  Temperature: 27
  Initial conditions: /reset = 0; /Vout = 0; /net1 = 0
  Analysis tran: stop=100u errpreset=conservative
  Signals: /Vout, /reset, /vo2, /Vi
Run mode: Single Run, Sweeps and Corners
Setup values for test lablib:FinalProject_ADC:1: Vin = -.1m
