ADE simulation setup
Test lablib:FinalProject_ADC:1: lablib/FinalProject_ADC/schematic, simulator spectre
  Models: $CDK_DIR/models/spectre/standalone/tsmc25N.m, $CDK_DIR/models/spectre/standalone/tsmc25P.m, $CDK_DIR/models/spectre/standalone/tsmc35N.m, $CDK_DIR/models/spectre/standalone/tsmc35P.m, $CDK_DIR/models/spectre/standalone/ami06N.m, $CDK_DIR/models/spectre/nom/ami06P.m, $CDK_DIR/models/spectre/nom/ami06N.m
  Variables: Vin = -.1m; Vrefx = .1m; C = 1u; R = 100k
  Temperature: 27
  Initial conditions: /Vout = -2.5; /net1 = -2.5
  Analysis tran: stop=2m errpreset=conservative
  Signals: /Vout, /Vout2, /P0/D (terminal)
