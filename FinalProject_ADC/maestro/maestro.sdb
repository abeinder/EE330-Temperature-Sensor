ADE simulation setup
Run mode: Single Run, Sweeps and Corners
Tests:
  lablib:FinalProject_ADC:1: lablib/FinalProject_ADC/schematic, simulator spectre
    Variables: C = 1u; R = 100k; Vin = -.1m; Vrefx = .1m
